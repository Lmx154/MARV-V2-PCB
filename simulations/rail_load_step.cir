MARV V2 - illustrative 3.3 V rail impedance/load-step experiment
* NOT a model of a selected regulator or proof of flight readiness.
* Assumptions: source impedance 0.10 ohm + 100 nH,
* effective bulk capacitance 47 uF, ESR 30 milliohm,
* 100 mA baseline and an additional 200 mA pulse with 1 us edges.
* Replace these values with actual regulator/PCB/load data when selected.
.param CBULK=47u
Vrail source 0 3.3
Rsource source feed 0.10
Ltrace feed rail 100n
Resr rail bulk 0.03
Cbulk bulk 0 {CBULK}
Rceramic rail ceramic 0.01
Cceramic ceramic 0 100n
Iidle rail 0 0.1
Istep rail 0 PULSE(0 0.2 1m 1u 1u 1m 3m)
.tran 50n 4m
.meas tran vbaseline FIND v(rail) AT=0.9m
.meas tran vmin MIN v(rail) FROM=0.9m TO=2.5m
.meas tran vmax MAX v(rail) FROM=0.9m TO=2.5m
.meas tran vloaded FIND v(rail) AT=1.9m
.meas tran vrecovered FIND v(rail) AT=2.9m
.end
