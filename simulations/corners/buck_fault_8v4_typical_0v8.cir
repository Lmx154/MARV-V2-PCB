MARV P3 source-handover corner - TPS2121 behavioral model, not vendor silicon
* Self-contained (no .include elsewhere in this repo): duplicates the same
* muxctl/muxpath/reg subckts as integrated_power.cir. See that file's
* comments for why every nonlinearity in the state path is a tanh rather
* than a ?:/min/max clamp.
*
* The two sources are 5V_IN -- the output of U26, the on-board AP63205WU buck
* that makes 5.0 V from the 6-25.2 V pack on the ESC pad row J3 (0.10 ohm
* effective output impedance, 2 A limit) -- and USB (J4, 0.35 ohm, no limit),
* both entering ONE TPS2121 priority power mux (U25) whose OUT is V5_SYS.
* The pack itself is not modeled; this deck starts at the buck output.
* IN1 = 5V_IN is the priority input, IN2 = USB the fallback.
* Exactly one of them is the SURVIVOR (present for the whole run) and the
* other is the OTHER source (removed, inserted, or held over-voltage at
* t=15 ms); which is which is swapped in by tools/run_power_checks.py
* substituting the SURVIVOR / OTHER SOURCE / ROLE BLOCK text below. Both
* source blocks always drive into the same node names (srv/osrc, instances
* Xsurvivoror/Xotheror, top-level source Vsrv/Vother) and the ROLE BLOCK
* only decides which of them the controller treats as IN1, so every .meas
* statement is invariant across the substitutions:
*   vin5_removed_usb_present (on-disk default): USB survives, 5V_IN removed
*     (pack unplugged, or U26 shut down) while USB is already attached.
*   usb_removed_vin5_present: 5V_IN survives, USB removed.
*   usb_insert_vin5_present: 5V_IN survives, USB absent then inserted.
*   buck_fault_6v5 / buck_fault_8v4: USB survives, 5V_IN held above the OV1
*     trip for the whole run. With a fixed 5.00 V +/-1% buck there is no
*     external source left to mis-set or mis-plug, so these now model a U26
*     FAILURE pushing 6.5 V or 8.4 V onto 5V_IN (e.g. a shorted high-side
*     FET partially passing VBAT) and prove OV1 still protects V5_SYS.
*   Same hooks also produce the reverse-current corner in RESULTS.md (USB
*   inserted onto an already-present 5V_IN): current into the 5V_IN path is
*   directly measurable through Vsrv (the SURVIVOR block's own top-level
*   source).
*
* DEVICE NUMBERS, all from TPS2120/TPS2121 datasheet SLVSEA3F (rev F, Aug
* 2020), and all of them typical unless a corner substitutes otherwise:
*   RONHI 56 mOhm  - Sec 7.5 ON-RESISTANCE, TPS2121, VINx >= 5 V, 25 C
*                    (70 mOhm max at 25 C, 85 mOhm to 85 C, 100 mOhm to
*                    125 C; the worst-case corner substitutes 100 mOhm).
*   TSW 100 us     - Sec 7.5 tSW, the switchover time that applies with
*                    CP2 < VREF. The board ties CP2 to GND, so the 5 us
*                    tFSW fast-switchover path is deliberately NOT used and
*                    must not be modeled here.
*   TRCB 10 us     - Sec 7.5 tRCB, fast reverse-current blocking response.
*   IRCB 1 A       - Sec 7.5 IRCB typ (0.2 / 1 / 2 A); worst case 2 A.
*   VRCB 25 mV     - Sec 7.5 VRCB release voltage (0 / 25 / 50 mV).
*   VUVR/VUVF      - Sec 7.5 VUV,INx 2.65 V rising / 2.55 V falling.
*   VOVR 5.862 V   - Sec 9.3.5 / 10.2.4.2: OV1 engages when the OV1 divider
*   VOVF 5.751 V     node reaches VREF. Board divider R44 45.3k / R45 10k
*                    gives 10/55.3 = 0.180832, so VREF 1.06 V rising maps to
*                    5.862 V on 5V_IN and 1.04 V falling to 5.751 V.
*   VPRR 4.494 V   - Sec 10.2.4.1 Eq.5: PR1 divider R42 32.4k / R43 10k
*   VPRF 4.410 V     gives 10/42.4 = 0.235849, so VREF 1.06 V rising maps to
*                    4.494 V and 1.04 V falling to 4.410 V on 5V_IN. The divider
*                    is centred on the RISING edge so that even at the stacked
*                    worst case (5V_IN at its 4.75 V minimum, VREF at its 1.10 V
*                    maximum) the rising threshold is 4.664 V and IN1 is still
*                    selected inside the declared input window.
*   VCMP 280 mV    - Sec 7.5 VCOMP, the highest-voltage comparator offset
*                    used only when PR1 has already fallen below VREF.
* NOT MODELED: the SS-programmed startup slew (C70 100 nF -> 780 V/s, ~6.4 ms
* to 5 V per Table 9-1), gate/loop dynamics, current limiting (ILM 1.49 A,
* never approached by the modeled loads), thermal shutdown, and any bench
* measurement. Every predicate below is evaluated from 2 ms, after startup.
* VSYS bulk cap defaults to the schematic-nominal 20 uF ceramic (C8+C9); the
* worst-case corner substitutes the derated 14 uF value. A separate polymer
* branch (Cpoly+Rpolyesr) models C19, 100 uF nominal / 80 uF at the same
* -20% derating, with its 40 mOhm ESR in series.  C19 was a 220 uF / 10 V D
* case (176 uF derated) until the envelope re-pack; the B-case 100 uF part
* is what these decks now prove.
.param R5VIN=0.10 RUSB=0.35
.param RONHI=0.056 TSW=100u TRCB=10u IRCB=1 VRCB=0.025
.param VUVR=2.65 VUVF=2.55 VOVR=5.862 VOVF=5.751 VPRR=4.494 VPRF=4.410 VCMP=0.280
.param CSYS=20u CPOLY=100u ILOAD=0.8

* ---------------------------------------------------------------------------
* muxctl: the TPS2121's shared channel-selection logic. Unlike the LM66100
* pair it replaces, selection is NOT a per-channel decision: one controller
* looks at both inputs and enables exactly one channel, so priority has to be
* modeled at the top level. Ports are (IN1 IN2 EN1 EN2); EN1/EN2 are 0..1
* conduction commands consumed by the two muxpath instances.
* Implements Table 9-3 for the CP2 < VREF rows (the board grounds CP2):
*   IN1 drives OUT if IN1 is valid AND (PR1 > VREF, or IN2 is invalid, or the
*   VCOMP comparator picks IN1); otherwise IN2 drives OUT if IN2 is valid.
* Each comparator is a 1 us first-order latch whose threshold slides between
* its rising and falling value, which reproduces the datasheet hysteresis
* without a discontinuity for the solver to step across.
* ---------------------------------------------------------------------------
.subckt muxctl in1 in2 en1 en2 params: vuvr=2.65 vuvf=2.55 vovr=5.862 vovf=5.751 vprr=4.494 vprf=4.410 vcmp=0.280 tresp=1u
Cuv1 uv1 0 1
Ruv1bleed uv1 0 1e9
Buv1th uv1th 0 V=vuvr-(vuvr-vuvf)*v(uv1)
Buv1 0 uv1 I=(0.5*(1+tanh((v(in1)-v(uv1th))/0.010))-v(uv1))/tresp
Cuv2 uv2 0 1
Ruv2bleed uv2 0 1e9
Buv2th uv2th 0 V=vuvr-(vuvr-vuvf)*v(uv2)
Buv2 0 uv2 I=(0.5*(1+tanh((v(in2)-v(uv2th))/0.010))-v(uv2))/tresp
* OV1 only: the board grounds OV2, so the USB channel has no overvoltage cut.
Cov1 ov1 0 1
Rov1bleed ov1 0 1e9
Bov1th ov1th 0 V=vovr-(vovr-vovf)*v(ov1)
Bov1 0 ov1 I=(0.5*(1+tanh((v(in1)-v(ov1th))/0.010))-v(ov1))/tresp
Cpr pr 0 1
Rprbleed pr 0 1e9
Bprth prth 0 V=vprr-(vprr-vprf)*v(pr)
Bpr 0 pr I=(0.5*(1+tanh((v(in1)-v(prth))/0.010))-v(pr))/tresp
Bvc vc 0 V=0.5*(1+tanh((v(in1)-v(in2)-vcmp)/0.010))
Bvld1 vld1 0 V=v(uv1)*(1-v(ov1))
Bvld2 vld2 0 V=v(uv2)
Ben1 en1 0 V=v(vld1)*(v(pr)+(1-v(pr))*(1-(1-v(vc))*v(vld2)))
Ben2 en2 0 V=v(vld2)*(1-v(en1))
.ends

* ---------------------------------------------------------------------------
* muxpath: one TPS2121 channel (IN1->OUT or IN2->OUT), ports (IN OUT EN).
* THERE IS NO BODY DIODE. The channel is a pair of back-to-back FETs and
* Sec 9.3.6 says reverse-current blocking is always on for both channels, so
* a de-selected input neither sources nor sinks -- that is the property this
* replaces the LM66100 model for, and it means the hold-up capacitance, not a
* forward-biased diode, carries the load across a switchover.
*   rcb = reverse-blocking latch. Trips when the reverse drop implies a
*     reverse current above IRCB (v(out,in) > ircb*ron), releases when
*     v(out,in) falls back inside VRCB; time constant TRCB.
*   st  = conduction fraction. Follows the commanded state with time
*     constant TSW turning on and TRCB turning off; the rate is a tanh blend
*     of the two, not a ?:, so the Jacobian stays continuous.
* ---------------------------------------------------------------------------
.subckt muxpath in out en params: ron=0.056 tsw=100u trcb=10u ircb=1 vrcb=0.025
Crcb rcb 0 1
Rrcbbleed rcb 0 1e9
Brcbth rcbth 0 V=ircb*ron-(ircb*ron-vrcb)*v(rcb)
Brcb 0 rcb I=(0.5*(1+tanh((v(out,in)-v(rcbth))/0.005))-v(rcb))/trcb
Bcmd cmd 0 V=v(en)*(1-v(rcb))
Cst st 0 1
Rstbleed st 0 1e9
Bst 0 st I=(v(cmd)-v(st))*(1/trcb+(1/tsw-1/trcb)*0.5*(1+tanh((v(cmd)-v(st))/0.01)))
Bfet in out I=max(v(in,out)*v(st)/ron,-ircb)
.ends

.subckt reg in out params: setpoint=3.3 eta=0.9 vmin=2.5 rout=0.05 imax=0.8 cout=33u drop=0
Bvalid vld 0 V=0.5*(1+tanh((v(in)-vmin)/0.010))
Btarget target 0 V=min(setpoint,v(in)-drop)*v(vld)
Rsoft target control 1k
Csoft control 0 200n
Bdrive 0 drive I=v(vld)*min(max((v(control)-v(out))/rout,0),imax)
Vsense drive out 0
Binput in 0 I=max(v(out),0)*max(i(Vsense),0)/(eta*max(v(in),0.5))
Resr out cap 0.015
Cout cap 0 {cout}
Rbleed out 0 100k
.ends

* --- SURVIVOR SOURCE BLOCK: usb_survivor ---
* USB present for the whole run (no current limit): the surviving source in
* vin5_removed_usb_present and in both over-voltage corners. Held at the same
* 5.0 V as the OTHER source. The LM66100 model this file replaces had to
* split the two sources 4.6 V / 5.4 V to make the pre-event state
* well-defined, because that part had no priority mechanism and near-equal
* sources shared. The TPS2121 decides by PR1/OV1/VCOMP, not by which source
* happens to be higher, so the split is removed and both sources sit at
* their nominal 5.0 V -- a strictly harder case for the model, not a weaker
* one.
Vsrv vsrv0 0 5.0
Rsrvres vsrv0 srv {RUSB}
Csrvfilt srv 0 1.1u
Xsurvivoror srv sys ensrv muxpath params: ron={RONHI} tsw={TSW} trcb={TRCB} ircb={IRCB} vrcb={VRCB}
* --- END SURVIVOR SOURCE BLOCK ---

* --- OTHER SOURCE BLOCK: vin5_removed ---
* 5V_IN present from t=0 at 5.0 V, removed (100 us ramp) at t=15 ms.
* Current-limited like integrated_power.cir's B5vinlim (0.10 ohm slope, 2 A
* hard clamp = the AP63205's rated output). Cosrcfilt is the REAL 5V_IN node
* capacitance, not a token filter cap: C76/C77 2 x 22 uF (the AP63205 COUT of
* datasheet Table 3) + C71 100 nF = 44.1 uF. That value is load-bearing for
* this corner. With only a 100 nF pre-OR cap the node has so little charge
* that the still-conducting IN1 channel pins it to V5_SYS as the rail
* recovers, the PR1 divider never stays below VREF, and the model latches
* into a half-conducting state that the hardware cannot reach; with the real
* bulk the reverse current needed to drag 44.1 uF up exceeds IRCB, RCB trips
* within tRCB, and IN1 stays off. This node used to carry ~110 uF of XT30
* input network, so the corner is strictly harder than it was.
Vother vother0 0 8.4
Botherlim vother0 osrc I=min(max(v(vother0,osrc)/R5VIN,0),2.0)
Cosrcfilt osrc 0 44.1u
Rosrcbleed osrc 0 100k
Xotheror osrc sys enoth muxpath params: ron={RONHI} tsw={TSW} trcb={TRCB} ircb={IRCB} vrcb={VRCB}
* --- END OTHER SOURCE BLOCK ---

* --- ROLE BLOCK: other_is_in1 ---
* Default roles: the OTHER source is 5V_IN = IN1 (priority) and the SURVIVOR
* is USB = IN2. usb_removed_vin5_present / usb_insert_vin5_present swap this.
Xmuxctl osrc srv enoth ensrv muxctl params: vuvr={VUVR} vuvf={VUVF} vovr={VOVR} vovf={VOVF} vprr={VPRR} vprf={VPRF} vcmp={VCMP}
* --- END ROLE BLOCK ---

Csys sys 0 {CSYS}
Cpoly sys polyesr {CPOLY}
Rpolyesr polyesr 0 0.04
Vbuckin sys buckin 0
Xbuck buckin v3v3 reg setpoint=3.33 eta=0.92 vmin=3.0 rout=0.05 imax=3 cout=66u drop=0.15
Iload v3v3 0 {ILOAD}

.options method=gear reltol=0.001
.tran 0.5u 30m uic
.meas tran vsys_min MIN v(sys) FROM=2m TO=30m
.meas tran vsys_max MAX v(sys) FROM=2m TO=30m
.meas tran v3v3_min MIN v(v3v3) FROM=2m TO=30m
.meas tran v3v3_max MAX v(v3v3) FROM=2m TO=30m
* i(Vsrv) is negative for forward (survivor-sourcing) current and positive
* for reverse current flowing into the survivor (SPICE source convention),
* so the reverse-current peak is the MAXIMUM of i(Vsrv), not the minimum.
.meas tran rev_peak MAX i(Vsrv) FROM=2m TO=30m
.meas tran rev_dur INTEG par('(i(Vsrv)>0.02) ? 1 : 0') FROM=14m TO=25m
* Handover-validity precondition, per case (see tools/run_power_checks.py):
*   fet_pre  - survivor channel conduction just before the 15 ms event. For
*              vin5_removed_usb_present this must be ~0 (5V_IN has priority,
*              so the USB channel is held off); for usb_removed_vin5_present
*              it must be ~1 (5V_IN IS the survivor and holds priority).
*   oth_pre  - the other channel's conduction just before the event.
*   oth_max  - the other channel's conduction over the whole evaluated run;
*              this is how the over-voltage corners assert that IN1 is
*              rejected, since in those corners the OTHER source is 5V_IN.
*   src_pre / sys_pre - the other source, and the sys rail, were established.
.meas tran fet_pre MAX v(xsurvivoror.st) FROM=12m TO=14m
.meas tran oth_pre MAX v(xotheror.st) FROM=12m TO=14m
.meas tran oth_max MAX v(xotheror.st) FROM=2m TO=30m
.meas tran src_pre MIN v(osrc) FROM=5m TO=14m
.meas tran sys_pre MIN v(sys) FROM=5m TO=14m
* Reporting-only measures for the standing reverse-current corner (USB
* inserted onto a present 5V_IN): steady-state window 20-30 ms, well after
* the insertion transient.
.meas tran rev_avg AVG par('(i(Vsrv)>0) ? i(Vsrv) : 0') FROM=20m TO=30m
.meas tran sys_avg AVG v(sys) FROM=20m TO=30m
.meas tran fet_avg AVG v(xsurvivoror.st) FROM=20m TO=30m
.end
