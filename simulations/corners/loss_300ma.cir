MARV P3 integrated power - BEHAVIORAL architectural model, not vendor silicon
* Efficiencies, impedance, current limits, bandwidth and handover are assumptions.
* No EMI, USB enumeration, IC fault dynamics or switch losses.
* 5 V-only P3: two sources, 5V_IN (J3, BEC/boost) and USB (J4), entering ONE
* TPS2121 priority power mux (U25) whose OUT is V5_SYS -- no cell/battery path
* anywhere. IN1 = 5V_IN has priority, IN2 = USB is the fallback.
* The mux is modeled by the muxctl (shared selection logic) and muxpath (one
* channel) subckts below. Device numbers are all from TPS2120/TPS2121 datasheet
* SLVSEA3F rev F: RON 56 mOhm typ at VINx >= 5 V (Sec 7.5), tSW 100 us (Sec 7.5,
* the CP2 < VREF switchover time -- the board grounds CP2, so the 5 us tFSW path
* is deliberately not used), tRCB 10 us / IRCB 1 A / VRCB 25 mV (Sec 7.5, 9.3.6),
* VUV 2.65 V rising / 2.55 V falling, VCOMP 280 mV. VOVR/VOVF 5.862/5.751 V and
* VPRR/VPRF 4.494/4.410 V are the board's OV1 (R44 45.3k / R45 10k) and PR1
* (R42 32.4k / R43 10k) dividers referred back to the 5V_IN node through the
* datasheet VREF of 1.06 V rising / 1.04 V falling (Sec 9.3.5, 10.2.4.1-2).
* U7 TPS62913 (buck, V5_SYS->V3V3_SYS) and U12 TPS7A20 (LDO, V5_SYS->V3V3_ANA)
* are modeled by the reg/ldo subckts below.
.param R5VIN=0.10 RUSB=0.35 ETA_BUCK=0.92 COUT=66u
.param RONHI=0.056 TSW=100u TRCB=10u IRCB=1 VRCB=0.025
.param VUVR=2.65 VUVF=2.55 VOVR=5.862 VOVF=5.751 VPRR=4.494 VPRF=4.410 VCMP=0.280
.param CSYS=20u CPOLY=220u ILO=0.5 IHI=0.8 ILDO=10m
* Measurement window: the span over which a source is guaranteed present in
* the on-disk default (nominal) timing -- 5V_IN 5-40 ms, USB 30-55 ms, so a
* source is present continuously from 5 ms to 55 ms. usb_only/bec_only
* corners substitute TMSTART/TMEND to their own source's presence window.
* TFIRST is the arrival time of whichever source is first in the corner
* (5V_IN at 5 ms by default); the load schedule below is written relative to
* it so no source is ever loaded before it has had time to establish -- an
* always-on sink on an undriven rail would pull it far negative.
.param TFIRST=5m TMSTART=6.5m TMEND=54.9m

* ---------------------------------------------------------------------------
* muxctl: the TPS2121's shared channel-selection logic. Unlike the LM66100
* pair it replaces, selection is NOT a per-channel decision: one controller
* looks at both inputs and enables exactly one channel, so priority has to be
* modeled at the top level. Ports are (IN1 IN2 EN1 EN2); EN1/EN2 are 0..1
* conduction commands consumed by the two muxpath instances.
* Implements Table 9-3 for the CP2 < VREF rows (the board grounds CP2):
*   IN1 drives OUT if IN1 is valid AND (PR1 > VREF, or IN2 is invalid, or the
*   VCOMP comparator picks IN1); otherwise IN2 drives OUT if IN2 is valid.
* Each comparator is a 1 us first-order latch whose threshold slides between
* its rising and falling value, which reproduces the datasheet hysteresis
* without a discontinuity for the solver to step across.
* ---------------------------------------------------------------------------
.subckt muxctl in1 in2 en1 en2 params: vuvr=2.65 vuvf=2.55 vovr=5.862 vovf=5.751 vprr=4.494 vprf=4.410 vcmp=0.280 tresp=1u
Cuv1 uv1 0 1
Ruv1bleed uv1 0 1e9
Buv1th uv1th 0 V=vuvr-(vuvr-vuvf)*v(uv1)
Buv1 0 uv1 I=(0.5*(1+tanh((v(in1)-v(uv1th))/0.010))-v(uv1))/tresp
Cuv2 uv2 0 1
Ruv2bleed uv2 0 1e9
Buv2th uv2th 0 V=vuvr-(vuvr-vuvf)*v(uv2)
Buv2 0 uv2 I=(0.5*(1+tanh((v(in2)-v(uv2th))/0.010))-v(uv2))/tresp
* OV1 only: the board grounds OV2, so the USB channel has no overvoltage cut.
Cov1 ov1 0 1
Rov1bleed ov1 0 1e9
Bov1th ov1th 0 V=vovr-(vovr-vovf)*v(ov1)
Bov1 0 ov1 I=(0.5*(1+tanh((v(in1)-v(ov1th))/0.010))-v(ov1))/tresp
Cpr pr 0 1
Rprbleed pr 0 1e9
Bprth prth 0 V=vprr-(vprr-vprf)*v(pr)
Bpr 0 pr I=(0.5*(1+tanh((v(in1)-v(prth))/0.010))-v(pr))/tresp
Bvc vc 0 V=0.5*(1+tanh((v(in1)-v(in2)-vcmp)/0.010))
Bvld1 vld1 0 V=v(uv1)*(1-v(ov1))
Bvld2 vld2 0 V=v(uv2)
Ben1 en1 0 V=v(vld1)*(v(pr)+(1-v(pr))*(1-(1-v(vc))*v(vld2)))
Ben2 en2 0 V=v(vld2)*(1-v(en1))
.ends

* ---------------------------------------------------------------------------
* muxpath: one TPS2121 channel (IN1->OUT or IN2->OUT), ports (IN OUT EN).
* THERE IS NO BODY DIODE. The channel is a pair of back-to-back FETs and
* Sec 9.3.6 says reverse-current blocking is always on for both channels, so
* a de-selected input neither sources nor sinks -- that is the property this
* replaces the LM66100 model for, and it means the hold-up capacitance, not a
* forward-biased diode, carries the load across a switchover.
*   rcb = reverse-blocking latch. Trips when the reverse drop implies a
*     reverse current above IRCB (v(out,in) > ircb*ron), releases when
*     v(out,in) falls back inside VRCB; time constant TRCB.
*   st  = conduction fraction. Follows the commanded state with time
*     constant TSW turning on and TRCB turning off; the rate is a tanh blend
*     of the two, not a ?:, so the Jacobian stays continuous.
* ---------------------------------------------------------------------------
.subckt muxpath in out en params: ron=0.056 tsw=100u trcb=10u ircb=1 vrcb=0.025
Crcb rcb 0 1
Rrcbbleed rcb 0 1e9
Brcbth rcbth 0 V=ircb*ron-(ircb*ron-vrcb)*v(rcb)
Brcb 0 rcb I=(0.5*(1+tanh((v(out,in)-v(rcbth))/0.005))-v(rcb))/trcb
Bcmd cmd 0 V=v(en)*(1-v(rcb))
Cst st 0 1
Rstbleed st 0 1e9
Bst 0 st I=(v(cmd)-v(st))*(1/trcb+(1/tsw-1/trcb)*0.5*(1+tanh((v(cmd)-v(st))/0.01)))
Bfet in out I=max(v(in,out)*v(st)/ron,-ircb)
.ends

.subckt reg in out params: setpoint=3.3 eta=0.9 vmin=2.5 rout=0.05 imax=0.8 cout=33u drop=0
* Startup target ramps through an assumed 200 us filter.
* vld is the VIN-valid (UVLO) flag: 0 below vmin, 1 above, continuous (tanh)
* rather than a hard ?: step so ngspice's timestep does not collapse if a
* handover dip lets VIN reach vmin.
Bvalid vld 0 V=0.5*(1+tanh((v(in)-vmin)/0.010))
* Dropout clamp: the regulator cannot make more than (VIN-drop); drop=0
* (default) reproduces the old undropped behavior for callers that do not
* set it.
Btarget target 0 V=min(setpoint,v(in)-drop)*v(vld)
Rsoft target control 1k
Csoft control 0 200n
Bdrive 0 drive I=v(vld)*min(max((v(control)-v(out))/rout,0),imax)
Vsense drive out 0
* max(v(out),0): a transient UVLO dropout could otherwise swing v(out) negative and reverse the input-current term.
Binput in 0 I=max(v(out),0)*max(i(Vsense),0)/(eta*max(v(in),0.5))
Resr out cap 0.015
Cout cap 0 {cout}
Rbleed out 0 100k
.ends

.subckt ldo in out params: setpoint=3.3 vmin=2.5 drop=0.2 imax=0.05 cout=1u
* TPS7A20-class LDO: VOUT = min(setpoint, VIN-drop) once VIN>=vmin; ideal
* pass-through current (Iin=Iout), so P_loss = (VIN-VOUT)*IOUT falls out of
* the power balance directly rather than an assumed efficiency.
Bvalid vld 0 V=0.5*(1+tanh((v(in)-vmin)/0.010))
Btarget target 0 V=min(setpoint,v(in)-drop)*v(vld)
Rsoft target control 1k
Csoft control 0 200n
Bdrive 0 drive I=v(vld)*min(max((v(control)-v(out))/0.05,0),imax)
Vsense drive out 0
Binput in 0 I=max(i(Vsense),0)
Cout out 0 {cout}
Rbleed out 0 100k
.ends

* Nominal timing (on-disk default): 5V_IN present 5-40 ms, USB present
* 30-55 ms -- overlap 30-40 ms, and each is the sole source for a window
* (5V_IN alone 5-30 ms, USB alone 40-55 ms). usb_only/bec_only corners zero
* out one source's amplitude and adjust TMSTART/TMEND to that source's own
* presence window.
Vin5vinsrc v5vinsrc0 0 PWL(0 0 5m 0 5.1m 5.0 40m 5.0 40.1m 0)
* 5V_IN: external 2S-6S -> 5.0 V / 3 A BEC or 1S BMS/boost module. Modeled as
* a 0.10 ohm output impedance plus a 3 A hard current limit (behavioral
* clamp), not a vendor regulator model.
B5vinlim v5vinsrc0 v5vin I=min(max(v(v5vinsrc0,v5vin)/R5VIN,0),3.0)
* Real 5V_IN node capacitance: C16 100 nF + C67/C68 2 x 4.7 uF + C69 100 uF +
* C71 100 nF = ~110 uF. This is load-bearing at the 40 ms handover: with only a
* token filter cap the still-conducting IN1 channel pins 5V_IN to V5_SYS as the
* rail recovers and the mux model latches half-on, which the hardware cannot do.
C5vinfilt v5vin 0 110u
R5vinbleed v5vin 0 1meg
Vinusbsrc usbsrc0 0 PWL(0 0 30m 0 30.1m 5.0 55m 5.0 55.1m 0)
* USB: plain 5 V rail through cable/connector resistance; no current limit
* (USB compliance/negotiation is a firmware/operational matter, not modeled
* here).
Rusb usbsrc0 usb {RUSB}
Cusbfilt usb 0 1.1u
* Fixed roles here (unlike source_handover.cir, which swaps them): 5V_IN is IN1.
Xmuxctl v5vin usb en5vin enusb muxctl params: vuvr={VUVR} vuvf={VUVF} vovr={VOVR} vovf={VOVF} vprr={VPRR} vprf={VPRF} vcmp={VCMP}
X5vinor v5vin sys en5vin muxpath params: ron={RONHI} tsw={TSW} trcb={TRCB} ircb={IRCB} vrcb={VRCB}
Xusbor usb sys enusb muxpath params: ron={RONHI} tsw={TSW} trcb={TRCB} ircb={IRCB} vrcb={VRCB}
Csys sys 0 {CSYS}
Cpoly sys polyesr {CPOLY}
Rpolyesr polyesr 0 0.04
Vbuckin sys buckin 0
Xbuck buckin v3v3sys reg setpoint=3.33 eta={ETA_BUCK} vmin=3.0 rout=0.05 imax=3 cout={COUT} drop=0.15
Vldoin sys ldoin 0
Xldo ldoin v3v3ana ldo setpoint=3.3 vmin=2.5 drop=0.2 imax=0.05 cout=1u
* Load schedule relative to TFIRST (see above): zero until the first source
* has had time to establish, then baseline, then the 500->800->500 mA step
* well inside even the shortest single-source active window (usb_only's
* 25 ms), back to baseline through the end of the run.
Iloadsys v3v3sys 0 PWL(0 0 {TFIRST+0.2m} 0 {TFIRST+0.3m} 0.3 60m 0.3)
Iloadana v3v3ana 0 PWL(0 0 {TFIRST+0.2m} 0 {TFIRST+0.3m} {ILDO} 60m {ILDO})
.options method=gear reltol=0.001
.tran 1u 60m uic
.meas tran vout_min MIN v(v3v3sys) FROM={TMSTART} TO={TMEND}
.meas tran vout_max MAX v(v3v3sys) FROM={TMSTART} TO={TMEND}
.meas tran ana_min MIN v(v3v3ana) FROM={TMSTART} TO={TMEND}
.meas tran vsys_min MIN v(sys) FROM={TMSTART} TO={TMEND}
* FROM/TO=12m-14m falls inside the pure 500 mA (ILO) plateau (TFIRST+6.01m
* to TFIRST+11m = 11.01-16 ms at the default TFIRST=5m), not the earlier
* 0.03 A baseline segment or the 0.8 A peak.
.meas tran buck_loss AVG par('v(sys)*i(Vbuckin)-v(v3v3sys)*i(v.xbuck.vsense)') FROM=12m TO=14m
.meas tran ldo_loss AVG par('v(sys)*i(Vldoin)-v(v3v3ana)*i(v.xldo.vsense)') FROM=12m TO=14m
.end
